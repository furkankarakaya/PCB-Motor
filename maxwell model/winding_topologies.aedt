# Ansys Electronics Desktop project, version 2019.3
materials:
  NdFeB_PCB_N: CoordinateSystemType=Cylindrical permeability=1.05 conductivity=625000 magnetic_coercivity{Magnitude=-1007981.3A_per_meter DirComp1=0 DirComp2=0 DirComp3=-1}
  NdFeB_PCB_S: CoordinateSystemType=Cylindrical permeability=1.05 conductivity=625000 magnetic_coercivity{Magnitude=-1007981.3A_per_meter DirComp1=0 DirComp2=0 DirComp3=1}
  copper: permeability=0.999991 conductivity=58000000
  steel_1010: permittivity=1 permeability{HUnit=A_per_meter BUnit=tesla curve (0, 0) (238.7, 0.2003) (318.3, 0.3204) (358.1, 0.40045) (437.7, 0.50055) (477.5, 0.5606) (636.6, 0.7908) (795.8, 0.931) (1114.1, 1.1014) (1273.2, 1.2016) (1591.5, 1.302) (2228.2, 1.4028) (3183.1, 1.524) (4774.6, 1.626) (6366.2, 1.698) (7957.7, 1.73) (15915.5, 1.87) (31831, 1.99) (47746.5, 2.04) (63662, 2.07) (79577.5, 2.095) (159155, 2.2) (318310, 2.4)} conductivity=2000000 lande_g_factor=2
  vacuum: permittivity=1

design 2-ARC Winding (Maxwell 3D, Transient, model units mm)
options: Multiplier=fractions
variables:
  fractions = 4
  halfAxial = 0
  g_pcb = 1mm
  g_cu = 0.0694mm
  delta_r = d_trace+w_cu
  c = 4
  teta1 = (360/3/c/2) deg
  delta_x1 = d_trace/sin(teta1) meter
  w_cu = 0.8mm
  delta_x11 = w_cu/sin(teta1)
  g_cl = 0.5mm
  rin_pcb = 25mm
  l_core = 5mm
  l_mag = 2mm
  rout_mag = nint(1000*(rout_pcb-3*delta_r+w_cu/2))/1000
  rout_core = rout_mag
  rin_mag = rin_pcb
  rin_core = rin_mag
  mag_angle = 144deg
  p = 16
  rout_pcb = 49mm
  d_trace = 0.2mm
  n_rpm = 1500rpm
  frequ = p*n_rpm/120*(30/pi) Hz
  t_per = 1/frequ s
  theta_init = 41.25deg
  load_angle_deg = 0
  load_angle_rad = (load_angle_deg*pi/180) rad
  I_rms = 2A
geometry:
  Tool = user_primitive(RMxprt/Band, DiaGap=113mm, DiaYoke=192mm, Length=200mm, SegAngle=1.5789474deg, Fractions=fractions, HalfAxial=halfAxial, InfoCore=1)
  Tool.move(0mm, 0mm, 2.25mm)
  Rotor_Core [steel_1010] = user_primitive(RMxprt/DiskPMCore, DiaOuter=2*rout_core, DiaInner=2*rin_core, Thickness=l_core, Gap=g_pcb/2+g_cl, Skew=0deg, Poles=12, Embrace=0.7, ThickMag=l_mag, InfoCore=0)
  Tool_3 = Tool.copy()
  Rotor_Core.subtract(Tool_3)
  Tool.delete()
  coordinate_system RelativeCS1 = origin=(delta_x1, 0mm, 0mm) x=(1mm, 0mm, 0mm) y=(0mm, 1mm, 0mm)
  coordinate_system RelativeCS2 = origin=(delta_x1, 0mm, 0mm) x=(1mm, 0mm, 0mm) y=(0mm, 1mm, 0mm)
  coordinate_system RelativeCS3 = origin=(delta_x1+delta_x11, 0mm, 0mm) x=(1mm, 0mm, 0mm) y=(0mm, 1mm, 0mm)
  coordinate_system RelativeCS4 = origin=(delta_x1, 0mm, 0mm) x=(1mm, 0mm, 0mm) y=(0mm, 1mm, 0mm) in RelativeCS3
  coordinate_system RelativeCS5 = origin=(delta_x1+delta_x11, 0mm, 0mm) x=(1mm, 0mm, 0mm) y=(0mm, 1mm, 0mm) in RelativeCS3
  coordinate_system RelativeCS6 = origin=(delta_x1+delta_x11, 0mm, 0mm) x=(1mm, 0mm, 0mm) y=(0mm, 1mm, 0mm) in RelativeCS5
  coordinate_system RelativeCS7 = origin=(delta_x1, 0mm, 0mm) x=(1mm, 0mm, 0mm) y=(0mm, 1mm, 0mm) in RelativeCS5
  coordinate_system RelativeCS8 = origin=(delta_x1+delta_x11, 0mm, 0mm) x=(1mm, 0mm, 0mm) y=(0mm, 1mm, 0mm) in RelativeCS5
  coordinate_system RelativeCS9 = origin=(delta_x1, 0mm, 0mm) x=(1mm, 0mm, 0mm) y=(0mm, 1mm, 0mm)
  coordinate_system RelativeCS10 = origin=(delta_x1+delta_x11, 0mm, 0mm) x=(1mm, 0mm, 0mm) y=(0mm, 1mm, 0mm)
  coordinate_system RelativeCS11 = origin=(delta_x1, 0mm, 0mm) x=(1mm, 0mm, 0mm) y=(0mm, 1mm, 0mm) in RelativeCS10
  coordinate_system RelativeCS12 = origin=(delta_x1+delta_x11, 0mm, 0mm) x=(1mm, 0mm, 0mm) y=(0mm, 1mm, 0mm) in RelativeCS10
  coordinate_system RelativeCS13 = origin=(delta_x1, 0mm, 0mm) x=(1mm, 0mm, 0mm) y=(0mm, 1mm, 0mm) in RelativeCS12
  coordinate_system RelativeCS14 = origin=(delta_x1+delta_x11, 0mm, 0mm) x=(1mm, 0mm, 0mm) y=(0mm, 1mm, 0mm) in RelativeCS12
  coordinate_system RelativeCS15 = origin=(delta_x1, 0mm, 0mm) x=(1mm, 0mm, 0mm) y=(0mm, 1mm, 0mm)
  coordinate_system RelativeCS16 = origin=(delta_x1+delta_x11, 0mm, 0mm) x=(1mm, 0mm, 0mm) y=(0mm, 1mm, 0mm)
  coordinate_system RelativeCS17 = origin=(delta_x1+delta_x11, 0mm, 0mm) x=(1mm, 0mm, 0mm) y=(0mm, 1mm, 0mm)
  Band [vacuum] = user_primitive(RMxprt/Band, DiaGap=2*rout_mag+7mm, DiaYoke=2*rout_mag+6mm, Length=g_pcb+g_cl, SegAngle=0deg, Fractions=fractions, HalfAxial=0, InfoCore=0)
  OuterRegion [vacuum] = user_primitive(RMxprt/Band, DiaGap=100mm, DiaYoke=2*rout_pcb+4mm, Length=2*l_core+g_pcb+2*l_mag+2*g_cl, SegAngle=1deg, Fractions=fractions, HalfAxial=0, InfoCore=100)
  MasterSheet [vacuum] = user_primitive(RMxprt/Band, DiaGap=2*rout_pcb+6mm, DiaYoke=2*rout_pcb+10mm, Length=2*l_core+2*l_mag+g_pcb+2*g_cl, SegAngle=1.5789474deg, Fractions=fractions, HalfAxial=0, InfoCore=2)
  SlaveSheet [vacuum] = user_primitive(RMxprt/Band, DiaGap=2*rout_pcb+6mm, DiaYoke=2*rout_pcb+10mm, Length=2*l_core+2*l_mag+g_pcb+2*g_cl, SegAngle=1.5789474deg, Fractions=fractions, HalfAxial=0, InfoCore=3)
  Inner_region [vacuum] = user_primitive(RMxprt/Band, DiaGap=100mm, DiaYoke=2*rout_mag+4mm, Length=g_pcb, SegAngle=1deg, Fractions=fractions, HalfAxial=0, InfoCore=100)
  coordinate_system RelativeCS18 = origin=(delta_x1, 0mm, 0mm) x=(1mm, 0mm, 0mm) y=(0mm, 1mm, 0mm)
  coordinate_system RelativeCS19 = origin=(delta_x1+delta_x11, 0mm, 0mm) x=(1mm, 0mm, 0mm) y=(0mm, 1mm, 0mm)
  coordinate_system RelativeCS20 = origin=(delta_x1, 0mm, 0mm) x=(1mm, 0mm, 0mm) y=(0mm, 1mm, 0mm) in RelativeCS19
  coordinate_system RelativeCS21 = origin=(delta_x1+delta_x11, 0mm, 0mm) x=(1mm, 0mm, 0mm) y=(0mm, 1mm, 0mm) in RelativeCS19
  coordinate_system RelativeCS22 = origin=(delta_x1, 0mm, 0mm) x=(1mm, 0mm, 0mm) y=(0mm, 1mm, 0mm) in RelativeCS21
  coordinate_system RelativeCS23 = origin=(delta_x1+delta_x11, 0mm, 0mm) x=(1mm, 0mm, 0mm) y=(0mm, 1mm, 0mm) in RelativeCS21
  coordinate_system RelativeCS27 = origin=(4*delta_x1+3*delta_x11, 0mm, 0mm) x=(1mm, 0mm, 0mm) y=(0mm, 1mm, 0mm)
  coordinate_system RelativeCS28 = origin=(4*delta_x1+4*delta_x11, 0mm, 0mm) x=(1mm, 0mm, 0mm) y=(0mm, 1mm, 0mm)
  coordinate_system RelativeCS30 = origin=(5*delta_x1+4*delta_x11, 0mm, 0mm) x=(1mm, 0mm, 0mm) y=(0mm, 1mm, 0mm)
  coordinate_system RelativeCS31 = origin=(5*delta_x1+5*delta_x11, 0mm, 0mm) x=(1mm, 0mm, 0mm) y=(0mm, 1mm, 0mm)
  coordinate_system RelativeCS32 = origin=(delta_x1, 0mm, 0mm) x=(1mm, 0mm, 0mm) y=(0mm, 1mm, 0mm)
  coordinate_system RelativeCS33 = origin=(delta_x1+delta_x11, 0mm, 0mm) x=(1mm, 0mm, 0mm) y=(0mm, 1mm, 0mm)
  coordinate_system RelativeCS34 = origin=(delta_x1, 0mm, 0mm) x=(1mm, 0mm, 0mm) y=(0mm, 1mm, 0mm) in RelativeCS33
  coordinate_system RelativeCS35 = origin=(delta_x1+delta_x11, 0mm, 0mm) x=(1mm, 0mm, 0mm) y=(0mm, 1mm, 0mm) in RelativeCS33
  coordinate_system RelativeCS36 = origin=(delta_x1, 0mm, 0mm) x=(1mm, 0mm, 0mm) y=(0mm, 1mm, 0mm) in RelativeCS35
  coordinate_system RelativeCS37 = origin=(delta_x1+delta_x11, 0mm, 0mm) x=(1mm, 0mm, 0mm) y=(0mm, 1mm, 0mm) in RelativeCS35
  coordinate_system RelativeCS38 = origin=(4*delta_x1+3*delta_x11, 0mm, 0mm) x=(1mm, 0mm, 0mm) y=(0mm, 1mm, 0mm)
  coordinate_system RelativeCS39 = origin=(4*delta_x1+4*delta_x11, 0mm, 0mm) x=(1mm, 0mm, 0mm) y=(0mm, 1mm, 0mm)
  coordinate_system RelativeCS40 = origin=(6*delta_x1+5*delta_x11, 0mm, 0mm) x=(1mm, 0mm, 0mm) y=(0mm, 1mm, 0mm)
  coordinate_system RelativeCS41 = origin=(6*delta_x1+6*delta_x11, 0mm, 0mm) x=(1mm, 0mm, 0mm) y=(0mm, 1mm, 0mm)
  coordinate_system RelativeCS42 = origin=(delta_x1, 0mm, 0mm) x=(1mm, 0mm, 0mm) y=(0mm, 1mm, 0mm)
  coordinate_system RelativeCS43 = origin=(delta_x1+delta_x11, 0mm, 0mm) x=(1mm, 0mm, 0mm) y=(0mm, 1mm, 0mm)
  coordinate_system RelativeCS44 = origin=(delta_x1, 0mm, 0mm) x=(1mm, 0mm, 0mm) y=(0mm, 1mm, 0mm) in RelativeCS43
  coordinate_system RelativeCS45 = origin=(delta_x1+delta_x11, 0mm, 0mm) x=(1mm, 0mm, 0mm) y=(0mm, 1mm, 0mm) in RelativeCS43
  coordinate_system RelativeCS46 = origin=(delta_x1, 0mm, 0mm) x=(1mm, 0mm, 0mm) y=(0mm, 1mm, 0mm) in RelativeCS45
  coordinate_system RelativeCS47 = origin=(delta_x1+delta_x11, 0mm, 0mm) x=(1mm, 0mm, 0mm) y=(0mm, 1mm, 0mm) in RelativeCS45
  coordinate_system RelativeCS48 = origin=(4*delta_x1+3*delta_x11, 0mm, 0mm) x=(1mm, 0mm, 0mm) y=(0mm, 1mm, 0mm)
  coordinate_system RelativeCS49 = origin=(4*delta_x1+4*delta_x11, 0mm, 0mm) x=(1mm, 0mm, 0mm) y=(0mm, 1mm, 0mm)
  coordinate_system RelativeCS50 = origin=(5*delta_x1+4*delta_x11, 0mm, 0mm) x=(1mm, 0mm, 0mm) y=(0mm, 1mm, 0mm)
  coordinate_system RelativeCS51 = origin=(5*delta_x1+5*delta_x11, 0mm, 0mm) x=(1mm, 0mm, 0mm) y=(0mm, 1mm, 0mm)
  Mag_N [NdFeB_PCB_N] = user_primitive(RMxprt/DiskPMCore, DiaOuter=2*rout_mag, DiaInner=2*rin_mag, Thickness=l_mag, Gap=g_pcb/2+g_cl, Skew=0deg, Poles=p, Embrace=mag_angle/180deg, ThickMag=l_mag, InfoCore=2)
  Mag_N_1 [NdFeB_PCB_S], Mag_N_2 [NdFeB_PCB_N], Mag_N_3 [NdFeB_PCB_S] = Mag_N.duplicate_around_axis(axis=Z, angle=360deg/p, total=4)
  Mag_N_4 [NdFeB_PCB_N] = Mag_N.duplicate_mirror(point=(0mm, 0mm, 0mm), normal=(0mm, 0mm, -1mm))
  Mag_N_2_1 [NdFeB_PCB_N] = Mag_N_2.duplicate_mirror(point=(0mm, 0mm, 0mm), normal=(0mm, 0mm, -1mm))
  Rotor_Core_1 [steel_1010] = Rotor_Core.duplicate_mirror(point=(0mm, 0mm, 0mm), normal=(0mm, 0mm, -1mm))
  Mag_N_1_1 [NdFeB_PCB_S] = Mag_N_1.duplicate_mirror(point=(0mm, 0mm, 0mm), normal=(0mm, 0mm, -1mm))
  Mag_N_3_1 [NdFeB_PCB_S] = Mag_N_3.duplicate_mirror(point=(0mm, 0mm, 0mm), normal=(0mm, 0mm, -1mm))
  coordinate_system RelativeCS52 = origin=(delta_x1, 0mm, 0mm) x=(1mm, 0mm, 0mm) y=(0mm, 1mm, 0mm)
  coordinate_system RelativeCS53 = origin=(delta_x1+delta_x11, 0mm, 0mm) x=(1mm, 0mm, 0mm) y=(0mm, 1mm, 0mm)
  coordinate_system RelativeCS54 = origin=(delta_x1, 0mm, 0mm) x=(1mm, 0mm, 0mm) y=(0mm, 1mm, 0mm) in RelativeCS53
  coordinate_system RelativeCS55 = origin=(delta_x1+delta_x11, 0mm, 0mm) x=(1mm, 0mm, 0mm) y=(0mm, 1mm, 0mm) in RelativeCS53
  coordinate_system RelativeCS56 = origin=(delta_x1, 0mm, 0mm) x=(1mm, 0mm, 0mm) y=(0mm, 1mm, 0mm) in RelativeCS55
  coordinate_system RelativeCS57 = origin=(delta_x1+delta_x11, 0mm, 0mm) x=(1mm, 0mm, 0mm) y=(0mm, 1mm, 0mm) in RelativeCS55
  coordinate_system RelativeCS58 = origin=(4*delta_x1+3*delta_x11, 0mm, 0mm) x=(1mm, 0mm, 0mm) y=(0mm, 1mm, 0mm)
  coordinate_system RelativeCS59 = origin=(4*delta_x1+4*delta_x11, 0mm, 0mm) x=(1mm, 0mm, 0mm) y=(0mm, 1mm, 0mm)
  coordinate_system RelativeCS60 = origin=(5*delta_x1+4*delta_x11, 0mm, 0mm) x=(1mm, 0mm, 0mm) y=(0mm, 1mm, 0mm)
  coordinate_system RelativeCS61 = origin=(5*delta_x1+5*delta_x11, 0mm, 0mm) x=(1mm, 0mm, 0mm) y=(0mm, 1mm, 0mm)
  coordinate_system RelativeCS62 = origin=(6*delta_x1+5*delta_x11, 0mm, 0mm) x=(1mm, 0mm, 0mm) y=(0mm, 1mm, 0mm)
  coordinate_system RelativeCS63 = origin=(6*delta_x1+6*delta_x11, 0mm, 0mm) x=(1mm, 0mm, 0mm) y=(0mm, 1mm, 0mm)
  coordinate_system RelativeCS64 = origin=(delta_x1, 0mm, 0mm) x=(1mm, 0mm, 0mm) y=(0mm, 1mm, 0mm)
  coordinate_system RelativeCS65 = origin=(delta_x1+delta_x11, 0mm, 0mm) x=(1mm, 0mm, 0mm) y=(0mm, 1mm, 0mm)
  coordinate_system RelativeCS66 = origin=(delta_x1, 0mm, 0mm) x=(1mm, 0mm, 0mm) y=(0mm, 1mm, 0mm) in RelativeCS65
  coordinate_system RelativeCS67 = origin=(delta_x1+delta_x11, 0mm, 0mm) x=(1mm, 0mm, 0mm) y=(0mm, 1mm, 0mm) in RelativeCS65
  coordinate_system RelativeCS68 = origin=(delta_x1, 0mm, 0mm) x=(1mm, 0mm, 0mm) y=(0mm, 1mm, 0mm) in RelativeCS67
  coordinate_system RelativeCS69 = origin=(delta_x1+delta_x11, 0mm, 0mm) x=(1mm, 0mm, 0mm) y=(0mm, 1mm, 0mm) in RelativeCS67
  coordinate_system RelativeCS70 = origin=(4*delta_x1+3*delta_x11, 0mm, 0mm) x=(1mm, 0mm, 0mm) y=(0mm, 1mm, 0mm)
  coordinate_system RelativeCS71 = origin=(4*delta_x1+4*delta_x11, 0mm, 0mm) x=(1mm, 0mm, 0mm) y=(0mm, 1mm, 0mm)
  coordinate_system RelativeCS72 = origin=(5*delta_x1+4*delta_x11, 0mm, 0mm) x=(1mm, 0mm, 0mm) y=(0mm, 1mm, 0mm)
  coordinate_system RelativeCS73 = origin=(5*delta_x1+5*delta_x11, 0mm, 0mm) x=(1mm, 0mm, 0mm) y=(0mm, 1mm, 0mm)
  coordinate_system RelativeCS74 = origin=(6*delta_x1+5*delta_x11, 0mm, 0mm) x=(1mm, 0mm, 0mm) y=(0mm, 1mm, 0mm)
  coordinate_system RelativeCS75 = origin=(6*delta_x1+6*delta_x11, 0mm, 0mm) x=(1mm, 0mm, 0mm) y=(0mm, 1mm, 0mm)
  coordinate_system RelativeCS78 = origin=(6*delta_x1+6*delta_x11, 0mm, 0mm) x=(1mm, 0mm, 0mm) y=(0mm, 1mm, 0mm)
  coordinate_system RelativeCS76 = origin=(delta_x1, 0mm, 0mm) x=(1mm, 0mm, 0mm) y=(0mm, 1mm, 0mm)
  coordinate_system RelativeCS77 = origin=(delta_x1+delta_x11, 0mm, 0mm) x=(1mm, 0mm, 0mm) y=(0mm, 1mm, 0mm)
  coordinate_system RelativeCS90 = origin=(6*delta_x1+6*delta_x11, 0mm, 0mm) x=(1mm, 0mm, 0mm) y=(0mm, 1mm, 0mm)
  coordinate_system RelativeCS91 = origin=(delta_x1, 0mm, 0mm) x=(1mm, 0mm, 0mm) y=(0mm, 1mm, 0mm)
  coordinate_system RelativeCS92 = origin=(delta_x1+delta_x11, 0mm, 0mm) x=(1mm, 0mm, 0mm) y=(0mm, 1mm, 0mm)
  band_top, band_top_1, band_top_2, band_top_3, band_top_1_1, band_top_2_1 [vacuum] = imported_body()
  Circle1 = circle(normal=Z, centre=(30mm, 0mm, 0mm), radius=20.129mm)
  Circle2 = circle(normal=Z, centre=(0mm, 0mm, 0mm), radius=30mm)
  Circle3 = circle(normal=Z, centre=(0mm, 0mm, 0mm), radius=46mm)
  Circle3.subtract(Circle1)
  Circle4 = circle(normal=Z, centre=(0mm, 0mm, 0mm), radius=25mm)
  Circle3.subtract(Circle4)
  group Region = Band, OuterRegion, MasterSheet, SlaveSheet, Inner_region
  group mesh_sheet = band_top, band_top_1, band_top_2, band_top_3, band_top_1_1, band_top_2_1
motion:
  MotionSetup1: Band Move_Type=Rotate Coordinate_System=Global Axis=Z Is_Positive=true InitPos=theta_init Angular_Velocity=n_rpm Objects=Band
  Moving1: Moving Objects=[Inner_region, band_top, band_top_1, band_top_3, band_top_2_1]
boundaries and excitations:
  Master1: Master Faces=MasterSheet.face(at (27, 0, 0)) CoordSysVector{middle of MasterSheet.edge(at (0, 0, 0)) -> middle of MasterSheet.edge(at (54, 0, 0))} ReverseV
  Slave1: Slave Faces=SlaveSheet.face(at (0, 27, 0)) CoordSysVector{middle of SlaveSheet.edge(at (0, 0, 0)) -> middle of SlaveSheet.edge(at (0, 54, 0))} ReverseV master=Master1 RelationIsSame=true
  PhaseA: Winding Group Type=Current IsSolid=false Current=I_rms*sqrt(2)*sin(2*pi*frequ*time) ParallelBranchesNum=1
  PhaseC: Winding Group Type=Current IsSolid=false Current=I_rms*sqrt(2)*sin(2*pi*frequ*time-2*pi/3+load_angle_rad) ParallelBranchesNum=1
  PhaseB: Winding Group Type=Current IsSolid=false Current=I_rms*sqrt(2)*sin(2*pi*frequ*time+2*pi/3+load_angle_rad) ParallelBranchesNum=1
  eddy effects on: Rotor_Core, Mag_N, Mag_N_1..Mag_N_4, Mag_N_2_1, Rotor_Core_1, Mag_N_1_1, Mag_N_3_1
  external circuit: "* Design: MaxCir3"
mesh:
  core: LengthBased RefineInside Objects=[Rotor_Core, Rotor_Core_1] MaxLength=4mm
  CylindricalGap_band: CylindricalGap BandMappingAngle=3deg MovingSideLayers=1 StaticSideLayers=1 Objects=Band
  magnets: LengthBased RefineInside Objects=[Mag_N, Mag_N_2, Mag_N_1, Mag_N_3, Mag_N_2_1, Mag_N_4, Mag_N_3_1, Mag_N_1_1] MaxLength=2mm
  mesh_sheet: LengthBased Objects=[band_top, band_top_1, band_top_1_1, band_top_2, band_top_2_1, band_top_3] MaxLength=1mm
  band: LengthBased RefineInside Objects=Band MaxLength=1mm
  initial mesh: GlobalCurvilinear{Apply} MeshMethod=AnsoftTAU
setups:
  Setup1: Transient NonlinearSolverResidual=0.0001 ScalarPotential="Second Order" SmoothBHCurve StopTime=2*t_per TimeStep=t_per/100 SaveFieldsType=Custom SweepRanges{0ns to 2*t_per-t_per/10 step t_per/10 point 0.01s point 0.01s point 0.01s point 0.01s point 0.01s point 0.01s point 0.01s point 0.01s point 0.01s point 0.01s point 0.01s point 0.01s point 0.01s point 0.01s point 0.01s point 0.01s point 0.01s point 0.01s point 0.01s point 0.01s point 0.01s point 0.01s point 0.01s point 0.01s point 0.01s point 0.01s point 0.01s point 0.01s point 0.01s point 0.01s point 0.01s point 0.01s point 0.01s point 0.01s point 0.01s point 0.01s point 0.01s point 0.01s point 0.01s point 0.01s point 0.01s point 0.01s point 0.01s point 0.01s point 0.01s point 0.01s point 0.01s point 0.01s point 0.01s point 0.01s point 0.01s point 0.01s point 0.01s point 0.01s point 0.01s point 0.01s point 0.01s point 0.01s point 0.01s point 0.01s point 0.01s point 0.01s point 0.01s point 0.01s point 0.01s point 0.01s point 0.01s point 0.01s point 0.01s point 0.01s point 0.01s point 0.01s point 0.01s point 0.01s point 0.01s point 0.01s point 0.01s point 0.01s point 0.01s point 0.01s point 0.01s point 0.01s point 0.01s} NumberSolveSteps=1 RangeStart=0s RangeEnd=0.1s
field calculator expressions:
  B_Z = Fundamental_Quantity(62) | ScalarZ
field plots:
  Mag_B1: B in Rotor_Core on Setup1 : Transient at Time=-1
reports:
  A fazÄ± akÄ±mÄ±, giris ve induced voltajÄ±: InducedVoltage(PhaseA), InputVoltage(PhaseA), Current(PhaseA) vs Time on Setup1 : Transient
  tork: Moving1.Torque vs Time on Setup1 : Transient
  faz akÄ±mlarÄ±: Current(PhaseA), Current(PhaseC), Current(PhaseB) vs Time on Setup1 : Transient
  induced voltages: InducedVoltage(PhaseA), InducedVoltage(PhaseC), InducedVoltage(PhaseB) vs Time on Setup1 : Transient
  Loss Plot 1: SolidLoss vs Time on Setup1 : Transient

design 1 - Concentric Winding (Maxwell 3D, Transient, model units mm)
options: Multiplier=fractions
variables:
  fractions = 4
  halfAxial = 0
  g_pcb = 2*g_cu+g_pcb_core+2*g_pcb_ins
  g_cu = 0.07mm
  delta_r = d_trace+w_cu
  c = 4
  teta1 = (360/3/c/2) deg
  delta_x1 = d_trace/sin(teta1) meter
  w_cu = 0.8mm
  delta_x11 = w_cu/sin(teta1)
  g_cl = 1mm
  rin_pcb = 25mm
  l_core = 5mm
  l_mag = 2mm
  rout_mag = nint(1000*(rout_pcb-3*delta_r+w_cu/2))/1000
  rout_core = rout_mag
  rin_mag = rin_pcb
  rin_core = rin_mag
  mag_angle = 144deg
  p = 16
  rout_pcb = 49mm
  d_trace = 0.2mm
  n_rpm = 1500rpm
  frequ = p*n_rpm/120*(30/pi) Hz
  t_per = 1/frequ s
  theta_init = 41.25deg
  load_angle_deg = 0
  load_angle_rad = (load_angle_deg*pi/180) rad
  I_rms = 2A
  g_pcb_core = 0.72mm
  g_pcb_ins = 0.07mm
geometry:
  Tool = user_primitive(RMxprt/Band, DiaGap=113mm, DiaYoke=192mm, Length=200mm, SegAngle=1.5789474deg, Fractions=fractions, HalfAxial=halfAxial, InfoCore=1)
  Tool.move(0mm, 0mm, 2.25mm)
  Rotor_Core [steel_1010] = user_primitive(RMxprt/DiskPMCore, DiaOuter=2*rout_core, DiaInner=2*rin_core, Thickness=l_core, Gap=g_pcb/2+g_cl, Skew=0deg, Poles=12, Embrace=0.7, ThickMag=l_mag, InfoCore=0)
  Tool_3 = Tool.copy()
  Rotor_Core.subtract(Tool_3)
  Tool.delete()
  coordinate_system RelativeCS1 = origin=(delta_x1, 0mm, 0mm) x=(1mm, 0mm, 0mm) y=(0mm, 1mm, 0mm)
  coordinate_system RelativeCS2 = origin=(delta_x1, 0mm, 0mm) x=(1mm, 0mm, 0mm) y=(0mm, 1mm, 0mm)
  coordinate_system RelativeCS3 = origin=(delta_x1+delta_x11, 0mm, 0mm) x=(1mm, 0mm, 0mm) y=(0mm, 1mm, 0mm)
  coordinate_system RelativeCS4 = origin=(delta_x1, 0mm, 0mm) x=(1mm, 0mm, 0mm) y=(0mm, 1mm, 0mm) in RelativeCS3
  coordinate_system RelativeCS5 = origin=(delta_x1+delta_x11, 0mm, 0mm) x=(1mm, 0mm, 0mm) y=(0mm, 1mm, 0mm) in RelativeCS3
  coordinate_system RelativeCS6 = origin=(delta_x1+delta_x11, 0mm, 0mm) x=(1mm, 0mm, 0mm) y=(0mm, 1mm, 0mm) in RelativeCS5
  coordinate_system RelativeCS7 = origin=(delta_x1, 0mm, 0mm) x=(1mm, 0mm, 0mm) y=(0mm, 1mm, 0mm) in RelativeCS5
  coordinate_system RelativeCS8 = origin=(delta_x1+delta_x11, 0mm, 0mm) x=(1mm, 0mm, 0mm) y=(0mm, 1mm, 0mm) in RelativeCS5
  coordinate_system RelativeCS9 = origin=(delta_x1, 0mm, 0mm) x=(1mm, 0mm, 0mm) y=(0mm, 1mm, 0mm)
  coordinate_system RelativeCS10 = origin=(delta_x1+delta_x11, 0mm, 0mm) x=(1mm, 0mm, 0mm) y=(0mm, 1mm, 0mm)
  coordinate_system RelativeCS11 = origin=(delta_x1, 0mm, 0mm) x=(1mm, 0mm, 0mm) y=(0mm, 1mm, 0mm) in RelativeCS10
  coordinate_system RelativeCS12 = origin=(delta_x1+delta_x11, 0mm, 0mm) x=(1mm, 0mm, 0mm) y=(0mm, 1mm, 0mm) in RelativeCS10
  coordinate_system RelativeCS13 = origin=(delta_x1, 0mm, 0mm) x=(1mm, 0mm, 0mm) y=(0mm, 1mm, 0mm) in RelativeCS12
  coordinate_system RelativeCS14 = origin=(delta_x1+delta_x11, 0mm, 0mm) x=(1mm, 0mm, 0mm) y=(0mm, 1mm, 0mm) in RelativeCS12
  coordinate_system RelativeCS15 = origin=(delta_x1, 0mm, 0mm) x=(1mm, 0mm, 0mm) y=(0mm, 1mm, 0mm)
  coordinate_system RelativeCS16 = origin=(delta_x1+delta_x11, 0mm, 0mm) x=(1mm, 0mm, 0mm) y=(0mm, 1mm, 0mm)
  coordinate_system RelativeCS17 = origin=(delta_x1+delta_x11, 0mm, 0mm) x=(1mm, 0mm, 0mm) y=(0mm, 1mm, 0mm)
  Band [vacuum] = user_primitive(RMxprt/Band, DiaGap=2*rout_mag+7mm, DiaYoke=2*rout_mag+6mm, Length=g_pcb+g_cl, SegAngle=0deg, Fractions=fractions, HalfAxial=0, InfoCore=0)
  OuterRegion [vacuum] = user_primitive(RMxprt/Band, DiaGap=100mm, DiaYoke=2*rout_pcb+4mm, Length=2*l_core+g_pcb+2*l_mag+2*g_cl, SegAngle=1deg, Fractions=fractions, HalfAxial=0, InfoCore=100)
  MasterSheet [vacuum] = user_primitive(RMxprt/Band, DiaGap=2*rout_pcb+6mm, DiaYoke=2*rout_pcb+10mm, Length=2*l_core+2*l_mag+g_pcb+2*g_cl, SegAngle=1.5789474deg, Fractions=fractions, HalfAxial=0, InfoCore=2)
  SlaveSheet [vacuum] = user_primitive(RMxprt/Band, DiaGap=2*rout_pcb+6mm, DiaYoke=2*rout_pcb+10mm, Length=2*l_core+2*l_mag+g_pcb+2*g_cl, SegAngle=1.5789474deg, Fractions=fractions, HalfAxial=0, InfoCore=3)
  Inner_region [vacuum] = user_primitive(RMxprt/Band, DiaGap=100mm, DiaYoke=2*rout_mag+4mm, Length=g_pcb, SegAngle=1deg, Fractions=fractions, HalfAxial=0, InfoCore=100)
  coordinate_system RelativeCS18 = origin=(delta_x1, 0mm, 0mm) x=(1mm, 0mm, 0mm) y=(0mm, 1mm, 0mm)
  coordinate_system RelativeCS19 = origin=(delta_x1+delta_x11, 0mm, 0mm) x=(1mm, 0mm, 0mm) y=(0mm, 1mm, 0mm)
  coordinate_system RelativeCS20 = origin=(delta_x1, 0mm, 0mm) x=(1mm, 0mm, 0mm) y=(0mm, 1mm, 0mm) in RelativeCS19
  coordinate_system RelativeCS21 = origin=(delta_x1+delta_x11, 0mm, 0mm) x=(1mm, 0mm, 0mm) y=(0mm, 1mm, 0mm) in RelativeCS19
  coordinate_system RelativeCS22 = origin=(delta_x1, 0mm, 0mm) x=(1mm, 0mm, 0mm) y=(0mm, 1mm, 0mm) in RelativeCS21
  coordinate_system RelativeCS23 = origin=(delta_x1+delta_x11, 0mm, 0mm) x=(1mm, 0mm, 0mm) y=(0mm, 1mm, 0mm) in RelativeCS21
  coordinate_system RelativeCS27 = origin=(4*delta_x1+3*delta_x11, 0mm, 0mm) x=(1mm, 0mm, 0mm) y=(0mm, 1mm, 0mm)
  coordinate_system RelativeCS28 = origin=(4*delta_x1+4*delta_x11, 0mm, 0mm) x=(1mm, 0mm, 0mm) y=(0mm, 1mm, 0mm)
  coordinate_system RelativeCS30 = origin=(5*delta_x1+4*delta_x11, 0mm, 0mm) x=(1mm, 0mm, 0mm) y=(0mm, 1mm, 0mm)
  coordinate_system RelativeCS31 = origin=(5*delta_x1+5*delta_x11, 0mm, 0mm) x=(1mm, 0mm, 0mm) y=(0mm, 1mm, 0mm)
  coordinate_system RelativeCS32 = origin=(delta_x1, 0mm, 0mm) x=(1mm, 0mm, 0mm) y=(0mm, 1mm, 0mm)
  coordinate_system RelativeCS33 = origin=(delta_x1+delta_x11, 0mm, 0mm) x=(1mm, 0mm, 0mm) y=(0mm, 1mm, 0mm)
  coordinate_system RelativeCS34 = origin=(delta_x1, 0mm, 0mm) x=(1mm, 0mm, 0mm) y=(0mm, 1mm, 0mm) in RelativeCS33
  coordinate_system RelativeCS35 = origin=(delta_x1+delta_x11, 0mm, 0mm) x=(1mm, 0mm, 0mm) y=(0mm, 1mm, 0mm) in RelativeCS33
  coordinate_system RelativeCS36 = origin=(delta_x1, 0mm, 0mm) x=(1mm, 0mm, 0mm) y=(0mm, 1mm, 0mm) in RelativeCS35
  coordinate_system RelativeCS37 = origin=(delta_x1+delta_x11, 0mm, 0mm) x=(1mm, 0mm, 0mm) y=(0mm, 1mm, 0mm) in RelativeCS35
  coordinate_system RelativeCS38 = origin=(4*delta_x1+3*delta_x11, 0mm, 0mm) x=(1mm, 0mm, 0mm) y=(0mm, 1mm, 0mm)
  coordinate_system RelativeCS39 = origin=(4*delta_x1+4*delta_x11, 0mm, 0mm) x=(1mm, 0mm, 0mm) y=(0mm, 1mm, 0mm)
  coordinate_system RelativeCS40 = origin=(6*delta_x1+5*delta_x11, 0mm, 0mm) x=(1mm, 0mm, 0mm) y=(0mm, 1mm, 0mm)
  coordinate_system RelativeCS41 = origin=(6*delta_x1+6*delta_x11, 0mm, 0mm) x=(1mm, 0mm, 0mm) y=(0mm, 1mm, 0mm)
  coordinate_system RelativeCS42 = origin=(delta_x1, 0mm, 0mm) x=(1mm, 0mm, 0mm) y=(0mm, 1mm, 0mm)
  coordinate_system RelativeCS43 = origin=(delta_x1+delta_x11, 0mm, 0mm) x=(1mm, 0mm, 0mm) y=(0mm, 1mm, 0mm)
  coordinate_system RelativeCS44 = origin=(delta_x1, 0mm, 0mm) x=(1mm, 0mm, 0mm) y=(0mm, 1mm, 0mm) in RelativeCS43
  coordinate_system RelativeCS45 = origin=(delta_x1+delta_x11, 0mm, 0mm) x=(1mm, 0mm, 0mm) y=(0mm, 1mm, 0mm) in RelativeCS43
  coordinate_system RelativeCS46 = origin=(delta_x1, 0mm, 0mm) x=(1mm, 0mm, 0mm) y=(0mm, 1mm, 0mm) in RelativeCS45
  coordinate_system RelativeCS47 = origin=(delta_x1+delta_x11, 0mm, 0mm) x=(1mm, 0mm, 0mm) y=(0mm, 1mm, 0mm) in RelativeCS45
  coordinate_system RelativeCS48 = origin=(4*delta_x1+3*delta_x11, 0mm, 0mm) x=(1mm, 0mm, 0mm) y=(0mm, 1mm, 0mm)
  coordinate_system RelativeCS49 = origin=(4*delta_x1+4*delta_x11, 0mm, 0mm) x=(1mm, 0mm, 0mm) y=(0mm, 1mm, 0mm)
  coordinate_system RelativeCS50 = origin=(5*delta_x1+4*delta_x11, 0mm, 0mm) x=(1mm, 0mm, 0mm) y=(0mm, 1mm, 0mm)
  coordinate_system RelativeCS51 = origin=(5*delta_x1+5*delta_x11, 0mm, 0mm) x=(1mm, 0mm, 0mm) y=(0mm, 1mm, 0mm)
  Mag_N [NdFeB_PCB_N] = user_primitive(RMxprt/DiskPMCore, DiaOuter=2*rout_mag, DiaInner=2*rin_mag, Thickness=l_mag, Gap=g_pcb/2+g_cl, Skew=0deg, Poles=p, Embrace=mag_angle/180deg, ThickMag=l_mag, InfoCore=2)
  Mag_N_1 [NdFeB_PCB_S], Mag_N_2 [NdFeB_PCB_N], Mag_N_3 [NdFeB_PCB_S] = Mag_N.duplicate_around_axis(axis=Z, angle=360deg/p, total=4)
  Mag_N_4 [NdFeB_PCB_N] = Mag_N.duplicate_mirror(point=(0mm, 0mm, 0mm), normal=(0mm, 0mm, -1mm))
  Mag_N_2_1 [NdFeB_PCB_N] = Mag_N_2.duplicate_mirror(point=(0mm, 0mm, 0mm), normal=(0mm, 0mm, -1mm))
  Rotor_Core_1 [steel_1010] = Rotor_Core.duplicate_mirror(point=(0mm, 0mm, 0mm), normal=(0mm, 0mm, -1mm))
  Mag_N_1_1 [NdFeB_PCB_S] = Mag_N_1.duplicate_mirror(point=(0mm, 0mm, 0mm), normal=(0mm, 0mm, -1mm))
  Mag_N_3_1 [NdFeB_PCB_S] = Mag_N_3.duplicate_mirror(point=(0mm, 0mm, 0mm), normal=(0mm, 0mm, -1mm))
  coordinate_system RelativeCS52 = origin=(delta_x1, 0mm, 0mm) x=(1mm, 0mm, 0mm) y=(0mm, 1mm, 0mm)
  coordinate_system RelativeCS53 = origin=(delta_x1+delta_x11, 0mm, 0mm) x=(1mm, 0mm, 0mm) y=(0mm, 1mm, 0mm)
  coordinate_system RelativeCS54 = origin=(delta_x1, 0mm, 0mm) x=(1mm, 0mm, 0mm) y=(0mm, 1mm, 0mm) in RelativeCS53
  coordinate_system RelativeCS55 = origin=(delta_x1+delta_x11, 0mm, 0mm) x=(1mm, 0mm, 0mm) y=(0mm, 1mm, 0mm) in RelativeCS53
  coordinate_system RelativeCS56 = origin=(delta_x1, 0mm, 0mm) x=(1mm, 0mm, 0mm) y=(0mm, 1mm, 0mm) in RelativeCS55
  coordinate_system RelativeCS57 = origin=(delta_x1+delta_x11, 0mm, 0mm) x=(1mm, 0mm, 0mm) y=(0mm, 1mm, 0mm) in RelativeCS55
  coordinate_system RelativeCS58 = origin=(4*delta_x1+3*delta_x11, 0mm, 0mm) x=(1mm, 0mm, 0mm) y=(0mm, 1mm, 0mm)
  coordinate_system RelativeCS59 = origin=(4*delta_x1+4*delta_x11, 0mm, 0mm) x=(1mm, 0mm, 0mm) y=(0mm, 1mm, 0mm)
  coordinate_system RelativeCS60 = origin=(5*delta_x1+4*delta_x11, 0mm, 0mm) x=(1mm, 0mm, 0mm) y=(0mm, 1mm, 0mm)
  coordinate_system RelativeCS61 = origin=(5*delta_x1+5*delta_x11, 0mm, 0mm) x=(1mm, 0mm, 0mm) y=(0mm, 1mm, 0mm)
  coordinate_system RelativeCS62 = origin=(6*delta_x1+5*delta_x11, 0mm, 0mm) x=(1mm, 0mm, 0mm) y=(0mm, 1mm, 0mm)
  coordinate_system RelativeCS63 = origin=(6*delta_x1+6*delta_x11, 0mm, 0mm) x=(1mm, 0mm, 0mm) y=(0mm, 1mm, 0mm)
  coordinate_system RelativeCS64 = origin=(delta_x1, 0mm, 0mm) x=(1mm, 0mm, 0mm) y=(0mm, 1mm, 0mm)
  coordinate_system RelativeCS65 = origin=(delta_x1+delta_x11, 0mm, 0mm) x=(1mm, 0mm, 0mm) y=(0mm, 1mm, 0mm)
  coordinate_system RelativeCS66 = origin=(delta_x1, 0mm, 0mm) x=(1mm, 0mm, 0mm) y=(0mm, 1mm, 0mm) in RelativeCS65
  coordinate_system RelativeCS67 = origin=(delta_x1+delta_x11, 0mm, 0mm) x=(1mm, 0mm, 0mm) y=(0mm, 1mm, 0mm) in RelativeCS65
  coordinate_system RelativeCS68 = origin=(delta_x1, 0mm, 0mm) x=(1mm, 0mm, 0mm) y=(0mm, 1mm, 0mm) in RelativeCS67
  coordinate_system RelativeCS69 = origin=(delta_x1+delta_x11, 0mm, 0mm) x=(1mm, 0mm, 0mm) y=(0mm, 1mm, 0mm) in RelativeCS67
  coordinate_system RelativeCS70 = origin=(4*delta_x1+3*delta_x11, 0mm, 0mm) x=(1mm, 0mm, 0mm) y=(0mm, 1mm, 0mm)
  coordinate_system RelativeCS71 = origin=(4*delta_x1+4*delta_x11, 0mm, 0mm) x=(1mm, 0mm, 0mm) y=(0mm, 1mm, 0mm)
  coordinate_system RelativeCS72 = origin=(5*delta_x1+4*delta_x11, 0mm, 0mm) x=(1mm, 0mm, 0mm) y=(0mm, 1mm, 0mm)
  coordinate_system RelativeCS73 = origin=(5*delta_x1+5*delta_x11, 0mm, 0mm) x=(1mm, 0mm, 0mm) y=(0mm, 1mm, 0mm)
  coordinate_system RelativeCS74 = origin=(6*delta_x1+5*delta_x11, 0mm, 0mm) x=(1mm, 0mm, 0mm) y=(0mm, 1mm, 0mm)
  coordinate_system RelativeCS75 = origin=(6*delta_x1+6*delta_x11, 0mm, 0mm) x=(1mm, 0mm, 0mm) y=(0mm, 1mm, 0mm)
  coordinate_system RelativeCS78 = origin=(6*delta_x1+6*delta_x11, 0mm, 0mm) x=(1mm, 0mm, 0mm) y=(0mm, 1mm, 0mm)
  coordinate_system RelativeCS76 = origin=(delta_x1, 0mm, 0mm) x=(1mm, 0mm, 0mm) y=(0mm, 1mm, 0mm)
  coordinate_system RelativeCS77 = origin=(delta_x1+delta_x11, 0mm, 0mm) x=(1mm, 0mm, 0mm) y=(0mm, 1mm, 0mm)
  coordinate_system RelativeCS90 = origin=(6*delta_x1+6*delta_x11, 0mm, 0mm) x=(1mm, 0mm, 0mm) y=(0mm, 1mm, 0mm)
  coordinate_system RelativeCS91 = origin=(delta_x1, 0mm, 0mm) x=(1mm, 0mm, 0mm) y=(0mm, 1mm, 0mm)
  coordinate_system RelativeCS92 = origin=(delta_x1+delta_x11, 0mm, 0mm) x=(1mm, 0mm, 0mm) y=(0mm, 1mm, 0mm)
  band_top, band_top_1, band_top_2, band_top_3, band_top_1_1, band_top_2_1 [vacuum] = imported_body()
  coordinate_system RelativeCS93 = origin=(delta_x1, 0mm, 0mm) x=(1mm, 0mm, 0mm) y=(0mm, 1mm, 0mm)
  coordinate_system RelativeCS94 = origin=(delta_x1+delta_x11, 0mm, 0mm) x=(1mm, 0mm, 0mm) y=(0mm, 1mm, 0mm)
  coordinate_system RelativeCS95 = origin=(delta_x1, 0mm, 0mm) x=(1mm, 0mm, 0mm) y=(0mm, 1mm, 0mm) in RelativeCS94
  coordinate_system RelativeCS96 = origin=(delta_x1+delta_x11, 0mm, 0mm) x=(1mm, 0mm, 0mm) y=(0mm, 1mm, 0mm) in RelativeCS94
  coordinate_system RelativeCS97 = origin=(delta_x1, 0mm, 0mm) x=(1mm, 0mm, 0mm) y=(0mm, 1mm, 0mm) in RelativeCS96
  coordinate_system RelativeCS98 = origin=(delta_x1+delta_x11, 0mm, 0mm) x=(1mm, 0mm, 0mm) y=(0mm, 1mm, 0mm) in RelativeCS96
  coordinate_system RelativeCS99 = origin=(4*delta_x1+3*delta_x11, 0mm, 0mm) x=(1mm, 0mm, 0mm) y=(0mm, 1mm, 0mm)
  coordinate_system RelativeCS100 = origin=(4*delta_x1+4*delta_x11, 0mm, 0mm) x=(1mm, 0mm, 0mm) y=(0mm, 1mm, 0mm)
  coordinate_system RelativeCS101 = origin=(5*delta_x1+4*delta_x11, 0mm, 0mm) x=(1mm, 0mm, 0mm) y=(0mm, 1mm, 0mm)
  coordinate_system RelativeCS102 = origin=(5*delta_x1+5*delta_x11, 0mm, 0mm) x=(1mm, 0mm, 0mm) y=(0mm, 1mm, 0mm)
  coordinate_system RelativeCS103 = origin=(6*delta_x1+5*delta_x11, 0mm, 0mm) x=(1mm, 0mm, 0mm) y=(0mm, 1mm, 0mm)
  coordinate_system RelativeCS104 = origin=(6*delta_x1+6*delta_x11, 0mm, 0mm) x=(1mm, 0mm, 0mm) y=(0mm, 1mm, 0mm)
  coordinate_system RelativeCS105 = origin=(delta_x1, 0mm, 0mm) x=(1mm, 0mm, 0mm) y=(0mm, 1mm, 0mm)
  coordinate_system RelativeCS106 = origin=(delta_x1+delta_x11, 0mm, 0mm) x=(1mm, 0mm, 0mm) y=(0mm, 1mm, 0mm)
  coordinate_system RelativeCS107 = origin=(delta_x1, 0mm, 0mm) x=(1mm, 0mm, 0mm) y=(0mm, 1mm, 0mm) in RelativeCS106
  coordinate_system RelativeCS108 = origin=(delta_x1+delta_x11, 0mm, 0mm) x=(1mm, 0mm, 0mm) y=(0mm, 1mm, 0mm) in RelativeCS106
  coordinate_system RelativeCS109 = origin=(delta_x1, 0mm, 0mm) x=(1mm, 0mm, 0mm) y=(0mm, 1mm, 0mm) in RelativeCS108
  coordinate_system RelativeCS110 = origin=(delta_x1+delta_x11, 0mm, 0mm) x=(1mm, 0mm, 0mm) y=(0mm, 1mm, 0mm) in RelativeCS108
  coordinate_system RelativeCS111 = origin=(4*delta_x1+3*delta_x11, 0mm, 0mm) x=(1mm, 0mm, 0mm) y=(0mm, 1mm, 0mm)
  coordinate_system RelativeCS112 = origin=(4*delta_x1+4*delta_x11, 0mm, 0mm) x=(1mm, 0mm, 0mm) y=(0mm, 1mm, 0mm)
  coordinate_system RelativeCS113 = origin=(5*delta_x1+4*delta_x11, 0mm, 0mm) x=(1mm, 0mm, 0mm) y=(0mm, 1mm, 0mm)
  coordinate_system RelativeCS114 = origin=(5*delta_x1+5*delta_x11, 0mm, 0mm) x=(1mm, 0mm, 0mm) y=(0mm, 1mm, 0mm)
  coordinate_system RelativeCS115 = origin=(6*delta_x1+5*delta_x11, 0mm, 0mm) x=(1mm, 0mm, 0mm) y=(0mm, 1mm, 0mm)
  coordinate_system RelativeCS116 = origin=(6*delta_x1+6*delta_x11, 0mm, 0mm) x=(1mm, 0mm, 0mm) y=(0mm, 1mm, 0mm)
  coordinate_system RelativeCS117 = origin=(delta_x1, 0mm, 0mm) x=(1mm, 0mm, 0mm) y=(0mm, 1mm, 0mm)
  coordinate_system RelativeCS118 = origin=(delta_x1+delta_x11, 0mm, 0mm) x=(1mm, 0mm, 0mm) y=(0mm, 1mm, 0mm)
  coordinate_system RelativeCS119 = origin=(delta_x1, 0mm, 0mm) x=(1mm, 0mm, 0mm) y=(0mm, 1mm, 0mm) in RelativeCS118
  coordinate_system RelativeCS120 = origin=(delta_x1+delta_x11, 0mm, 0mm) x=(1mm, 0mm, 0mm) y=(0mm, 1mm, 0mm) in RelativeCS118
  coordinate_system RelativeCS121 = origin=(delta_x1, 0mm, 0mm) x=(1mm, 0mm, 0mm) y=(0mm, 1mm, 0mm) in RelativeCS120
  coordinate_system RelativeCS122 = origin=(delta_x1+delta_x11, 0mm, 0mm) x=(1mm, 0mm, 0mm) y=(0mm, 1mm, 0mm) in RelativeCS120
  coordinate_system RelativeCS123 = origin=(4*delta_x1+3*delta_x11, 0mm, 0mm) x=(1mm, 0mm, 0mm) y=(0mm, 1mm, 0mm)
  coordinate_system RelativeCS124 = origin=(4*delta_x1+4*delta_x11, 0mm, 0mm) x=(1mm, 0mm, 0mm) y=(0mm, 1mm, 0mm)
  coordinate_system RelativeCS125 = origin=(5*delta_x1+4*delta_x11, 0mm, 0mm) x=(1mm, 0mm, 0mm) y=(0mm, 1mm, 0mm)
  coordinate_system RelativeCS126 = origin=(5*delta_x1+5*delta_x11, 0mm, 0mm) x=(1mm, 0mm, 0mm) y=(0mm, 1mm, 0mm)
  turn1 [copper] = circle(normal=Z, centre=(0mm, 0mm, 0mm), radius=rout_pcb-3*delta_r+w_cu/2)
  Circle1 = circle(normal=Z, centre=(0mm, 0mm, 0mm), radius=rin_pcb+delta_r-w_cu/2)
  turn1.subtract(Circle1)
  coordinate_system RelativeCS127 = origin=(delta_x1, 0mm, 0mm) x=(1mm, 0mm, 0mm) y=(0mm, 1mm, 0mm)
  turn1.rotate(axis=Z, angle=teta1) in RelativeCS127
  turn1.split(plane=ZX, keep=PositiveOnly) in RelativeCS127
  turn1.rotate(axis=Z, angle=-2*teta1) in RelativeCS127
  turn1.split(plane=ZX, keep=NegativeOnly) in RelativeCS127
  turn1.rotate(axis=Z, angle=teta1) in RelativeCS127
  coordinate_system RelativeCS128 = origin=(delta_x1+delta_x11, 0mm, 0mm) x=(1mm, 0mm, 0mm) y=(0mm, 1mm, 0mm)
  Circle3 = circle(normal=Z, centre=(0mm, 0mm, 0mm), radius=rout_pcb-3*delta_r-w_cu/2)
  Circle4 = circle(normal=Z, centre=(0mm, 0mm, 0mm), radius=rin_pcb+delta_r+w_cu/2)
  Circle3.subtract(Circle4)
  Circle3.rotate(axis=Z, angle=teta1) in RelativeCS128
  Circle3.split(plane=ZX, keep=PositiveOnly) in RelativeCS128
  Circle3.rotate(axis=Z, angle=-2*teta1) in RelativeCS128
  Circle3.split(plane=ZX, keep=NegativeOnly) in RelativeCS128
  Circle3.rotate(axis=Z, angle=teta1) in RelativeCS128
  turn1.subtract(Circle3)
  turn1.sweep_along_vector((0mm, 0mm, g_cu))
  turn1.move(0mm, 0mm, g_pcb_core/2)
  turn1.rotate(axis=Z, angle=2*pi/3/c/2)
  turn1_1, turn1_2 [copper] = turn1.duplicate_around_axis(axis=Z, angle=360deg/3/c, total=3)
  turn1_7 [copper] = turn1.duplicate_along_line(step=(0mm, 0mm, -g_pcb-g_cu+g_pcb_ins*4), total=2)
  turn1_9 = turn1.copy()
  turn2 [copper] = circle(normal=Z, centre=(0mm, 0mm, 0mm), radius=rout_pcb-4*delta_r+w_cu/2)
  Circle6 = circle(normal=Z, centre=(0mm, 0mm, 0mm), radius=rin_pcb+2*delta_r-w_cu/2)
  turn2.subtract(Circle6)
  coordinate_system RelativeCS129 = origin=(delta_x1, 0mm, 0mm) x=(1mm, 0mm, 0mm) y=(0mm, 1mm, 0mm) in RelativeCS128
  turn2.rotate(axis=Z, angle=teta1) in RelativeCS129
  turn2.split(plane=ZX, keep=PositiveOnly) in RelativeCS129
  turn2.rotate(axis=Z, angle=-2*teta1) in RelativeCS129
  turn2.split(plane=ZX, keep=NegativeOnly) in RelativeCS129
  turn2.rotate(axis=Z, angle=teta1) in RelativeCS129
  coordinate_system RelativeCS130 = origin=(delta_x1+delta_x11, 0mm, 0mm) x=(1mm, 0mm, 0mm) y=(0mm, 1mm, 0mm) in RelativeCS128
  Circle7 = circle(normal=Z, centre=(0mm, 0mm, 0mm), radius=rout_pcb-4*delta_r-w_cu/2)
  Circle8 = circle(normal=Z, centre=(0mm, 0mm, 0mm), radius=rin_pcb+2*delta_r+w_cu/2)
  Circle7.subtract(Circle8)
  Circle7.rotate(axis=Z, angle=teta1) in RelativeCS130
  Circle7.split(plane=ZX, keep=PositiveOnly) in RelativeCS130
  Circle7.rotate(axis=Z, angle=-2*teta1) in RelativeCS130
  Circle7.split(plane=ZX, keep=NegativeOnly) in RelativeCS130
  Circle7.rotate(axis=Z, angle=teta1) in RelativeCS130
  turn2.subtract(Circle7)
  turn2.sweep_along_vector((0mm, 0mm, g_cu))
  turn2.move(0mm, 0mm, g_pcb_core/2)
  turn2.rotate(axis=Z, angle=2*pi/3/c/2)
  turn2_1, turn2_2 [copper] = turn2.duplicate_around_axis(axis=Z, angle=360deg/3/c, total=3)
  turn2_7 [copper] = turn2.duplicate_along_line(step=(0mm, 0mm, -g_pcb-g_cu+g_pcb_ins*4), total=2)
  turn2_9 = turn2.copy()
  turn3 [copper] = circle(normal=Z, centre=(0mm, 0mm, 0mm), radius=rout_pcb-5*delta_r+w_cu/2)
  Circle9 = circle(normal=Z, centre=(0mm, 0mm, 0mm), radius=rin_pcb+3*delta_r-w_cu/2)
  turn3.subtract(Circle9)
  coordinate_system RelativeCS131 = origin=(delta_x1, 0mm, 0mm) x=(1mm, 0mm, 0mm) y=(0mm, 1mm, 0mm) in RelativeCS130
  turn3.rotate(axis=Z, angle=teta1) in RelativeCS131
  turn3.split(plane=ZX, keep=PositiveOnly) in RelativeCS131
  turn3.rotate(axis=Z, angle=-2*teta1) in RelativeCS131
  turn3.split(plane=ZX, keep=NegativeOnly) in RelativeCS131
  turn3.rotate(axis=Z, angle=teta1) in RelativeCS131
  coordinate_system RelativeCS132 = origin=(delta_x1+delta_x11, 0mm, 0mm) x=(1mm, 0mm, 0mm) y=(0mm, 1mm, 0mm) in RelativeCS130
  Circle10 = circle(normal=Z, centre=(0mm, 0mm, 0mm), radius=rout_pcb-5*delta_r-w_cu/2)
  Circle11 = circle(normal=Z, centre=(0mm, 0mm, 0mm), radius=rin_pcb+3*delta_r+w_cu/2)
  Circle10.subtract(Circle11)
  Circle10.rotate(axis=Z, angle=teta1) in RelativeCS132
  Circle10.split(plane=ZX, keep=PositiveOnly) in RelativeCS132
  Circle10.rotate(axis=Z, angle=-2*teta1) in RelativeCS132
  Circle10.split(plane=ZX, keep=NegativeOnly) in RelativeCS132
  Circle10.rotate(axis=Z, angle=teta1) in RelativeCS132
  turn3.subtract(Circle10)
  turn3.sweep_along_vector((0mm, 0mm, g_cu))
  turn3.move(0mm, 0mm, g_pcb_core/2)
  turn3.rotate(axis=Z, angle=2*pi/3/c/2)
  turn3_1, turn3_2 [copper] = turn3.duplicate_around_axis(axis=Z, angle=360deg/3/c, total=3)
  turn3_7 [copper] = turn3.duplicate_along_line(step=(0mm, 0mm, -g_pcb-g_cu+g_pcb_ins*4), total=2)
  turn3_9 = turn3.copy()
  turn1_1_3 [copper] = turn1_1.duplicate_along_line(step=(0mm, 0mm, -g_pcb-g_cu+g_pcb_ins*4), total=2)
  turn1_2_3 [copper] = turn1_2.duplicate_along_line(step=(0mm, 0mm, -g_pcb-g_cu+g_pcb_ins*4), total=2)
  turn2_1_3 [copper] = turn2_1.duplicate_along_line(step=(0mm, 0mm, -g_pcb-g_cu+g_pcb_ins*4), total=2)
  turn2_2_3 [copper] = turn2_2.duplicate_along_line(step=(0mm, 0mm, -g_pcb-g_cu+g_pcb_ins*4), total=2)
  turn3_1_3 [copper] = turn3_1.duplicate_along_line(step=(0mm, 0mm, -g_pcb-g_cu+g_pcb_ins*4), total=2)
  turn3_2_3 [copper] = turn3_2.duplicate_along_line(step=(0mm, 0mm, -g_pcb-g_cu+g_pcb_ins*4), total=2)
  turn7 [copper] = circle(normal=Z, centre=(0mm, 0mm, 0mm), radius=rout_pcb-6*delta_r+w_cu/2)
  Circle21 = circle(normal=Z, centre=(0mm, 0mm, 0mm), radius=rin_pcb+4*delta_r-w_cu/2)
  turn7.subtract(Circle21)
  coordinate_system RelativeCS133 = origin=(4*delta_x1+3*delta_x11, 0mm, 0mm) x=(1mm, 0mm, 0mm) y=(0mm, 1mm, 0mm)
  turn7.rotate(axis=Z, angle=teta1) in RelativeCS133
  turn7.split(plane=ZX, keep=PositiveOnly) in RelativeCS133
  turn7.rotate(axis=Z, angle=-2*teta1) in RelativeCS133
  turn7.split(plane=ZX, keep=NegativeOnly) in RelativeCS133
  turn7.rotate(axis=Z, angle=teta1) in RelativeCS133
  coordinate_system RelativeCS134 = origin=(4*delta_x1+4*delta_x11, 0mm, 0mm) x=(1mm, 0mm, 0mm) y=(0mm, 1mm, 0mm)
  Circle22 = circle(normal=Z, centre=(0mm, 0mm, 0mm), radius=rout_pcb-6*delta_r-w_cu/2)
  Circle23 = circle(normal=Z, centre=(0mm, 0mm, 0mm), radius=rin_pcb+4*delta_r+w_cu/2)
  Circle22.subtract(Circle23)
  Circle22.rotate(axis=Z, angle=teta1) in RelativeCS134
  Circle22.split(plane=ZX, keep=PositiveOnly) in RelativeCS134
  Circle22.rotate(axis=Z, angle=-2*teta1) in RelativeCS134
  Circle22.split(plane=ZX, keep=NegativeOnly) in RelativeCS134
  Circle22.rotate(axis=Z, angle=teta1) in RelativeCS134
  turn7.subtract(Circle22)
  turn7.sweep_along_vector((0mm, 0mm, g_cu))
  turn7.move(0mm, 0mm, g_pcb_core/2)
  turn7.rotate(axis=Z, angle=2*pi/3/c/2)
  turn7_1, turn7_2 [copper] = turn7.duplicate_around_axis(axis=Z, angle=360deg/3/c, total=3)
  turn7_3 [copper] = turn7.duplicate_along_line(step=(0mm, 0mm, -g_pcb-g_cu+g_pcb_ins*4), total=2)
  turn7_5 = turn7.copy()
  turn7_1_1 [copper] = turn7_1.duplicate_along_line(step=(0mm, 0mm, -g_pcb-g_cu+g_pcb_ins*4), total=2)
  turn7_2_1 [copper] = turn7_2.duplicate_along_line(step=(0mm, 0mm, -g_pcb-g_cu+g_pcb_ins*4), total=2)
  turn8 [copper] = circle(normal=Z, centre=(0mm, 0mm, 0mm), radius=rout_pcb-7*delta_r+w_cu/2)
  Circle24 = circle(normal=Z, centre=(0mm, 0mm, 0mm), radius=rin_pcb+5*delta_r-w_cu/2)
  turn8.subtract(Circle24)
  coordinate_system RelativeCS135 = origin=(5*delta_x1+4*delta_x11, 0mm, 0mm) x=(1mm, 0mm, 0mm) y=(0mm, 1mm, 0mm)
  turn8.rotate(axis=Z, angle=teta1) in RelativeCS135
  turn8.split(plane=ZX, keep=PositiveOnly) in RelativeCS135
  turn8.rotate(axis=Z, angle=-2*teta1) in RelativeCS135
  turn8.split(plane=ZX, keep=NegativeOnly) in RelativeCS135
  turn8.rotate(axis=Z, angle=teta1) in RelativeCS135
  coordinate_system RelativeCS136 = origin=(5*delta_x1+5*delta_x11, 0mm, 0mm) x=(1mm, 0mm, 0mm) y=(0mm, 1mm, 0mm)
  Circle25 = circle(normal=Z, centre=(0mm, 0mm, 0mm), radius=rout_pcb-7*delta_r-w_cu/2)
  Circle26 = circle(normal=Z, centre=(0mm, 0mm, 0mm), radius=rin_pcb+5*delta_r+w_cu/2)
  Circle25.subtract(Circle26)
  Circle25.rotate(axis=Z, angle=teta1) in RelativeCS136
  Circle25.split(plane=ZX, keep=PositiveOnly) in RelativeCS136
  Circle25.rotate(axis=Z, angle=-2*teta1) in RelativeCS136
  Circle25.split(plane=ZX, keep=NegativeOnly) in RelativeCS136
  Circle25.rotate(axis=Z, angle=teta1) in RelativeCS136
  turn8.subtract(Circle25)
  turn8.sweep_along_vector((0mm, 0mm, g_cu))
  turn8.move(0mm, 0mm, g_pcb_core/2)
  turn8.rotate(axis=Z, angle=2*pi/3/c/2)
  turn8_1, turn8_2 [copper] = turn8.duplicate_around_axis(axis=Z, angle=360deg/3/c, total=3)
  turn8_3 [copper] = turn8.duplicate_along_line(step=(0mm, 0mm, -g_pcb-g_cu+g_pcb_ins*4), total=2)
  turn8_4 = turn8.copy()
  turn8_1_1 [copper] = turn8_1.duplicate_along_line(step=(0mm, 0mm, -g_pcb-g_cu+g_pcb_ins*4), total=2)
  turn8_2_1 [copper] = turn8_2.duplicate_along_line(step=(0mm, 0mm, -g_pcb-g_cu+g_pcb_ins*4), total=2)
  Coil4 = rectangle(corner=((rout_mag+rin_mag)/2, -1mm, -2mm), y_size=11mm, z_size=15mm)
  Coil5 = rectangle(corner=((rout_mag+rin_mag)/2, -1mm, -2mm), y_size=11mm, z_size=15mm)
  Coil5.subtract(turn1_9, turn2_9, turn3_9, turn7_5, turn8_4)
  Coil4.subtract(Coil5)
  Coil4_Separate1..Coil4_Separate4 = Coil4.separate_bodies()
  Coil4_1, Coil4_2 = Coil4.duplicate_around_axis(axis=Z, angle=360deg/3/c, total=3)
  Coil4_3 = Coil4.duplicate_along_line(step=(0mm, 0mm, -g_cu-g_pcb+4*g_pcb_ins), total=2)
  Coil4_Separate1_1, Coil4_Separate1_2 = Coil4_Separate1.duplicate_around_axis(axis=Z, angle=360deg/3/c, total=3)
  Coil4_Separate1_3 = Coil4_Separate1.duplicate_along_line(step=(0mm, 0mm, -g_cu-g_pcb+4*g_pcb_ins), total=2)
  Coil4_Separate2_1, Coil4_Separate2_2 = Coil4_Separate2.duplicate_around_axis(axis=Z, angle=360deg/3/c, total=3)
  Coil4_Separate2_3 = Coil4_Separate2.duplicate_along_line(step=(0mm, 0mm, -g_cu-g_pcb+4*g_pcb_ins), total=2)
  Coil4_Separate3_1, Coil4_Separate3_2 = Coil4_Separate3.duplicate_around_axis(axis=Z, angle=360deg/3/c, total=3)
  Coil4_Separate3_3 = Coil4_Separate3.duplicate_along_line(step=(0mm, 0mm, -g_cu-g_pcb+4*g_pcb_ins), total=2)
  Coil4_Separate4_1, Coil4_Separate4_2 = Coil4_Separate4.duplicate_around_axis(axis=Z, angle=360deg/3/c, total=3)
  Coil4_Separate4_3 = Coil4_Separate4.duplicate_along_line(step=(0mm, 0mm, -g_cu-g_pcb+4*g_pcb_ins), total=2)
  Coil4_Separate4_1_1 = Coil4_Separate4_1.duplicate_along_line(step=(0mm, 0mm, -g_cu-g_pcb+4*g_pcb_ins), total=2)
  Coil4_Separate4_2_1 = Coil4_Separate4_2.duplicate_along_line(step=(0mm, 0mm, -g_cu-g_pcb+4*g_pcb_ins), total=2)
  Coil4_Separate3_1_1 = Coil4_Separate3_1.duplicate_along_line(step=(0mm, 0mm, -g_cu-g_pcb+4*g_pcb_ins), total=2)
  Coil4_Separate3_2_1 = Coil4_Separate3_2.duplicate_along_line(step=(0mm, 0mm, -g_cu-g_pcb+4*g_pcb_ins), total=2)
  Coil4_Separate2_1_1 = Coil4_Separate2_1.duplicate_along_line(step=(0mm, 0mm, -g_cu-g_pcb+4*g_pcb_ins), total=2)
  Coil4_Separate2_2_1 = Coil4_Separate2_2.duplicate_along_line(step=(0mm, 0mm, -g_cu-g_pcb+4*g_pcb_ins), total=2)
  Coil4_Separate1_1_1 = Coil4_Separate1_1.duplicate_along_line(step=(0mm, 0mm, -g_cu-g_pcb+4*g_pcb_ins), total=2)
  Coil4_Separate1_2_1 = Coil4_Separate1_2.duplicate_along_line(step=(0mm, 0mm, -g_cu-g_pcb+4*g_pcb_ins), total=2)
  Coil4_1_1 = Coil4_1.duplicate_along_line(step=(0mm, 0mm, -g_cu-g_pcb+4*g_pcb_ins), total=2)
  Coil4_2_1 = Coil4_2.duplicate_along_line(step=(0mm, 0mm, -g_cu-g_pcb+4*g_pcb_ins), total=2)
  turn9 [copper] = circle(normal=Z, centre=(0mm, 0mm, 0mm), radius=rout_pcb-8*delta_r+w_cu/2)
  Circle27 = circle(normal=Z, centre=(0mm, 0mm, 0mm), radius=rin_pcb+6*delta_r-w_cu/2)
  turn9.subtract(Circle27)
  coordinate_system RelativeCS137 = origin=(6*delta_x1+5*delta_x11, 0mm, 0mm) x=(1mm, 0mm, 0mm) y=(0mm, 1mm, 0mm)
  turn9.rotate(axis=Z, angle=teta1) in RelativeCS137
  turn9.split(plane=ZX, keep=PositiveOnly) in RelativeCS137
  turn9.rotate(axis=Z, angle=-2*teta1) in RelativeCS137
  turn9.split(plane=ZX, keep=NegativeOnly) in RelativeCS137
  turn9.rotate(axis=Z, angle=teta1) in RelativeCS137
  coordinate_system RelativeCS138 = origin=(6*delta_x1+6*delta_x11, 0mm, 0mm) x=(1mm, 0mm, 0mm) y=(0mm, 1mm, 0mm)
  Circle28 = circle(normal=Z, centre=(0mm, 0mm, 0mm), radius=rout_pcb-8*delta_r-w_cu/2)
  Circle29 = circle(normal=Z, centre=(0mm, 0mm, 0mm), radius=rin_pcb+6*delta_r+w_cu/2)
  Circle28.subtract(Circle29)
  Circle28.rotate(axis=Z, angle=teta1) in RelativeCS138
  Circle28.split(plane=ZX, keep=PositiveOnly) in RelativeCS138
  Circle28.rotate(axis=Z, angle=-2*teta1) in RelativeCS138
  Circle28.split(plane=ZX, keep=NegativeOnly) in RelativeCS138
  Circle28.rotate(axis=Z, angle=teta1) in RelativeCS138
  turn9.subtract(Circle28)
  turn9.sweep_along_vector((0mm, 0mm, g_cu))
  turn9.move(0mm, 0mm, g_pcb_core/2)
  turn9.rotate(axis=Z, angle=2*pi/3/c/2)
  turn9_1, turn9_2 [copper] = turn9.duplicate_around_axis(axis=Z, angle=360deg/3/c, total=3)
  turn9_3 [copper] = turn9.duplicate_along_line(step=(0mm, 0mm, -g_pcb-g_cu+g_pcb_ins*4), total=2)
  turn9_4 = turn9.copy()
  turn9_1_1 [copper] = turn9_1.duplicate_along_line(step=(0mm, 0mm, -g_pcb-g_cu+g_pcb_ins*4), total=2)
  turn9_2_1 [copper] = turn9_2.duplicate_along_line(step=(0mm, 0mm, -g_pcb-g_cu+g_pcb_ins*4), total=2)
  turn9_3_1 = turn9_3.copy()
  Coil6 = rectangle(corner=((rout_mag+rin_mag)/2, -1mm, -2mm), y_size=11mm, z_size=15mm)
  Coil7 = rectangle(corner=((rout_mag+rin_mag)/2, -1mm, -2mm), y_size=11mm, z_size=15mm)
  Coil7.subtract(turn9_4, turn9_3_1)
  Coil6.subtract(Coil7)
  Coil6_1, Coil6_2 = Coil6.duplicate_around_axis(axis=Z, angle=360deg/3/c, total=3)
  Coil6_Separate1 = Coil6.separate_bodies()
  Coil6_1_Separate1 = Coil6_1.separate_bodies()
  Coil6_2_Separate1 = Coil6_2.separate_bodies()
  turn10 [copper] = circle(normal=Z, centre=(0mm, 0mm, 0mm), radius=rout_pcb-9*delta_r+w_cu/2)
  Circle30 = circle(normal=Z, centre=(0mm, 0mm, 0mm), radius=rin_pcb+7*delta_r-w_cu/2)
  turn10.subtract(Circle30)
  coordinate_system RelativeCS139 = origin=(7*delta_x1+6*delta_x11, 0mm, 0mm) x=(1mm, 0mm, 0mm) y=(0mm, 1mm, 0mm)
  turn10.rotate(axis=Z, angle=teta1) in RelativeCS139
  turn10.split(plane=ZX, keep=PositiveOnly) in RelativeCS139
  turn10.rotate(axis=Z, angle=-2*teta1) in RelativeCS139
  turn10.split(plane=ZX, keep=NegativeOnly) in RelativeCS139
  turn10.rotate(axis=Z, angle=teta1) in RelativeCS139
  coordinate_system RelativeCS140 = origin=(7*delta_x1+7*delta_x11, 0mm, 0mm) x=(1mm, 0mm, 0mm) y=(0mm, 1mm, 0mm)
  Circle31 = circle(normal=Z, centre=(0mm, 0mm, 0mm), radius=rout_pcb-9*delta_r-w_cu/2)
  Circle32 = circle(normal=Z, centre=(0mm, 0mm, 0mm), radius=rin_pcb+7*delta_r+w_cu/2)
  Circle31.subtract(Circle32)
  Circle31.rotate(axis=Z, angle=teta1) in RelativeCS140
  Circle31.split(plane=ZX, keep=PositiveOnly) in RelativeCS140
  Circle31.rotate(axis=Z, angle=-2*teta1) in RelativeCS140
  Circle31.split(plane=ZX, keep=NegativeOnly) in RelativeCS140
  Circle31.rotate(axis=Z, angle=teta1) in RelativeCS140
  turn10.subtract(Circle31)
  turn10.sweep_along_vector((0mm, 0mm, g_cu))
  turn10.move(0mm, 0mm, g_pcb_core/2)
  turn10.rotate(axis=Z, angle=2*pi/3/c/2)
  turn10_1, turn10_2 [copper] = turn10.duplicate_around_axis(axis=Z, angle=360deg/3/c, total=3)
  turn10_3 [copper] = turn10.duplicate_along_line(step=(0mm, 0mm, -g_pcb-g_cu+g_pcb_ins*4), total=2)
  turn10_4 = turn10.copy()
  turn10_1_1 [copper] = turn10_1.duplicate_along_line(step=(0mm, 0mm, -g_pcb-g_cu+g_pcb_ins*4), total=2)
  turn10_2_1 [copper] = turn10_2.duplicate_along_line(step=(0mm, 0mm, -g_pcb-g_cu+g_pcb_ins*4), total=2)
  turn10_3_1 = turn10_3.copy()
  7th_coil = rectangle(corner=((rout_mag+rin_mag)/2, -1mm, -2mm), y_size=11mm, z_size=15mm)
  7th_coil1 = rectangle(corner=((rout_mag+rin_mag)/2, -1mm, -2mm), y_size=11mm, z_size=15mm)
  7th_coil1.subtract(turn10_4, turn10_3_1)
  7th_coil.subtract(7th_coil1)
  7th_coil_1, 7th_coil_2 = 7th_coil.duplicate_around_axis(axis=Z, angle=360deg/3/c, total=3)
  7th_coil_Separate1 = 7th_coil.separate_bodies()
  7th_coil_1_Separate1 = 7th_coil_1.separate_bodies()
  7th_coil_2_Separate1 = 7th_coil_2.separate_bodies()
  group Region = Band, OuterRegion, MasterSheet, SlaveSheet, Inner_region
  group mesh_sheet = band_top, band_top_1, band_top_2, band_top_3, band_top_1_1, band_top_2_1
  group Coil_terminals = Coil4, Coil4_Separate1..Coil4_Separate4, Coil4_Separate4_1, Coil4_Separate4_2, Coil4_Separate3_1, Coil4_Separate3_2, Coil4_Separate2_1, Coil4_Separate2_2, Coil4_Separate1_1, Coil4_Separate1_2, Coil4_1, Coil4_2, Coil4_3, Coil4_1_1, Coil4_2_1, Coil4_Separate1_3, Coil4_Separate1_1_1, Coil4_Separate1_2_1, Coil4_Separate2_3, Coil4_Separate2_1_1, Coil4_Separate2_2_1, Coil4_Separate3_3, Coil4_Separate3_1_1, Coil4_Separate3_2_1, Coil4_Separate4_3, Coil4_Separate4_1_1, Coil4_Separate4_2_1, Coil6, Coil6_1, Coil6_2, Coil6_Separate1, Coil6_1_Separate1, Coil6_2_Separate1, 7th_coil, 7th_coil_1, 7th_coil_2, 7th_coil_Separate1, 7th_coil_1_Separate1, 7th_coil_2_Separate1
  group turns = turn1, turn2, turn3, turn1_1, turn1_2, turn2_1, turn2_2, turn3_1, turn3_2, turn1_7, turn2_7, turn3_7, turn1_1_3, turn1_2_3, turn2_1_3, turn2_2_3, turn3_1_3, turn3_2_3, turn7, turn7_1, turn7_2, turn7_2_1, turn7_1_1, turn7_3, turn8, turn8_1, turn8_2, turn8_3, turn8_1_1, turn8_2_1, turn9, turn9_1, turn9_2, turn9_2_1, turn9_1_1, turn9_3, turn10, turn10_1, turn10_2, turn10_1_1, turn10_3, turn10_2_1
motion:
  MotionSetup1: Band Move_Type=Rotate Coordinate_System=Global Axis=Z Is_Positive=true InitPos=theta_init Angular_Velocity=n_rpm Objects=Band
  Moving1: Moving Objects=[Inner_region, band_top, band_top_1, band_top_3, band_top_2_1, turn1, turn2, turn3, turn1_1, turn1_2, turn2_1, turn2_2, turn3_1, turn3_2, turn1_7, turn2_7, turn3_7, turn1_1_3, turn1_2_3, turn2_1_3, turn2_2_3, turn3_1_3, turn3_2_3, turn7, turn7_1, turn7_2, turn7_2_1, turn7_1_1, turn7_3, turn8, turn8_1, turn8_2, turn8_3, turn8_1_1, turn8_2_1, Coil4, Coil4_Separate1..Coil4_Separate4, Coil4_Separate4_1, Coil4_Separate4_2, Coil4_Separate3_1, Coil4_Separate3_2, Coil4_Separate2_1, Coil4_Separate2_2, Coil4_Separate1_1, Coil4_Separate1_2, Coil4_1, Coil4_2, Coil4_3, Coil4_1_1, Coil4_2_1, Coil4_Separate1_3, Coil4_Separate1_1_1, Coil4_Separate1_2_1, Coil4_Separate2_3, Coil4_Separate2_1_1, Coil4_Separate2_2_1, Coil4_Separate3_3, Coil4_Separate3_1_1, Coil4_Separate3_2_1, Coil4_Separate4_3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]
boundaries and excitations:
  Master1: Master Faces=MasterSheet.face(at (27, 0, 0)) CoordSysVector{middle of MasterSheet.edge(at (0, 0, 0)) -> middle of MasterSheet.edge(at (54, 0, 0))} ReverseV
  Slave1: Slave Faces=SlaveSheet.face(at (0, 27, 0)) CoordSysVector{middle of SlaveSheet.edge(at (0, 0, 0)) -> middle of SlaveSheet.edge(at (0, 54, 0))} ReverseV master=Master1 RelationIsSame=true
  a_1: Coil Terminal Objects=Coil4 Conductor_number=1 Winding=PhaseA Point_out_of_terminal=true
  a_2: Coil Terminal Objects=Coil4_Separate3 Conductor_number=1 Winding=PhaseA Point_out_of_terminal=true
  a_3: Coil Terminal Objects=Coil4_Separate1 Conductor_number=1 Winding=PhaseA Point_out_of_terminal=true
  a_4: Coil Terminal Objects=Coil4_Separate2 Conductor_number=1 Winding=PhaseA Point_out_of_terminal=true
  a_5: Coil Terminal Objects=Coil4_Separate4 Conductor_number=1 Winding=PhaseA Point_out_of_terminal=true
  a_6: Coil Terminal Objects=Coil6 Conductor_number=1 Winding=PhaseA Point_out_of_terminal=true
  a_7: Coil Terminal Objects=7th_coil Conductor_number=1 Winding=PhaseA Point_out_of_terminal=true
  a_8: Coil Terminal Objects=Coil4_3 Conductor_number=1 Winding=PhaseA Point_out_of_terminal=true
  a_9: Coil Terminal Objects=Coil4_Separate3_3 Conductor_number=1 Winding=PhaseA Point_out_of_terminal=true
  a_10: Coil Terminal Objects=Coil4_Separate1_3 Conductor_number=1 Winding=PhaseA Point_out_of_terminal=true
  a_11: Coil Terminal Objects=Coil4_Separate2_3 Conductor_number=1 Winding=PhaseA Point_out_of_terminal=true
  a_12: Coil Terminal Objects=Coil4_Separate4_3 Conductor_number=1 Winding=PhaseA Point_out_of_terminal=true
  a_13: Coil Terminal Objects=Coil6_Separate1 Conductor_number=1 Winding=PhaseA Point_out_of_terminal=true
  a_14: Coil Terminal Objects=7th_coil_Separate1 Conductor_number=1 Winding=PhaseA Point_out_of_terminal=true
  c_1: Coil Terminal Objects=Coil4_1 Conductor_number=1 Winding=PhaseC Point_out_of_terminal=true
  c_2: Coil Terminal Objects=Coil4_Separate3_1 Conductor_number=1 Winding=PhaseC Point_out_of_terminal=true
  c_3: Coil Terminal Objects=Coil4_Separate1_1 Conductor_number=1 Winding=PhaseC Point_out_of_terminal=true
  c_4: Coil Terminal Objects=Coil4_Separate2_1 Conductor_number=1 Winding=PhaseC Point_out_of_terminal=true
  c_5: Coil Terminal Objects=Coil4_Separate4_1 Conductor_number=1 Winding=PhaseC Point_out_of_terminal=true
  c_6: Coil Terminal Objects=Coil6_1 Conductor_number=1 Winding=PhaseC Point_out_of_terminal=true
  c_7: Coil Terminal Objects=7th_coil_1 Conductor_number=1 Winding=PhaseC Point_out_of_terminal=true
  c_8: Coil Terminal Objects=Coil4_1_1 Conductor_number=1 Winding=PhaseC Point_out_of_terminal=true
  c_9: Coil Terminal Objects=Coil4_Separate3_1_1 Conductor_number=1 Winding=PhaseC Point_out_of_terminal=true
  c_10: Coil Terminal Objects=Coil4_Separate1_1_1 Conductor_number=1 Winding=PhaseC Point_out_of_terminal=true
  c_11: Coil Terminal Objects=Coil4_Separate2_1_1 Conductor_number=1 Winding=PhaseC Point_out_of_terminal=true
  c_12: Coil Terminal Objects=Coil4_Separate4_1_1 Conductor_number=1 Winding=PhaseC Point_out_of_terminal=true
  c_13: Coil Terminal Objects=Coil6_1_Separate1 Conductor_number=1 Winding=PhaseC Point_out_of_terminal=true
  c_14: Coil Terminal Objects=7th_coil_1_Separate1 Conductor_number=1 Winding=PhaseC Point_out_of_terminal=true
  b_1: Coil Terminal Objects=Coil4_2 Conductor_number=1 Winding=PhaseB Point_out_of_terminal=true
  b_2: Coil Terminal Objects=Coil4_Separate3_2 Conductor_number=1 Winding=PhaseB Point_out_of_terminal=true
  b_3: Coil Terminal Objects=Coil4_Separate1_2 Conductor_number=1 Winding=PhaseB Point_out_of_terminal=true
  b_4: Coil Terminal Objects=Coil4_Separate2_2 Conductor_number=1 Winding=PhaseB Point_out_of_terminal=true
  b_5: Coil Terminal Objects=Coil4_Separate4_2 Conductor_number=1 Winding=PhaseB Point_out_of_terminal=true
  b_6: Coil Terminal Objects=Coil6_2 Conductor_number=1 Winding=PhaseB Point_out_of_terminal=true
  b_7: Coil Terminal Objects=7th_coil_2 Conductor_number=1 Winding=PhaseB Point_out_of_terminal=true
  b_8: Coil Terminal Objects=Coil4_2_1 Conductor_number=1 Winding=PhaseB Point_out_of_terminal=true
  b_9: Coil Terminal Objects=Coil4_Separate3_2_1 Conductor_number=1 Winding=PhaseB Point_out_of_terminal=true
  b_10: Coil Terminal Objects=Coil4_Separate1_2_1 Conductor_number=1 Winding=PhaseB Point_out_of_terminal=true
  b_11: Coil Terminal Objects=Coil4_Separate2_2_1 Conductor_number=1 Winding=PhaseB Point_out_of_terminal=true
  b_12: Coil Terminal Objects=Coil4_Separate4_2_1 Conductor_number=1 Winding=PhaseB Point_out_of_terminal=true
  b_13: Coil Terminal Objects=Coil6_2_Separate1 Conductor_number=1 Winding=PhaseB Point_out_of_terminal=true
  b_14: Coil Terminal Objects=7th_coil_2_Separate1 Conductor_number=1 Winding=PhaseB Point_out_of_terminal=true
  PhaseA: Winding Group Type=Current IsSolid=false Current=I_rms*sqrt(2)*sin(2*pi*frequ*time) ParallelBranchesNum=1
  PhaseC: Winding Group Type=Current IsSolid=false Current=I_rms*sqrt(2)*sin(2*pi*frequ*time-2*pi/3+load_angle_rad) ParallelBranchesNum=1
  PhaseB: Winding Group Type=Current IsSolid=false Current=I_rms*sqrt(2)*sin(2*pi*frequ*time+2*pi/3+load_angle_rad) ParallelBranchesNum=1
  eddy effects on: Rotor_Core, Mag_N, Mag_N_1..Mag_N_4, Mag_N_2_1, Rotor_Core_1, Mag_N_1_1, Mag_N_3_1, turn1, turn2, turn3, turn1_1, turn1_2, turn2_1, turn2_2, turn3_1, turn3_2, turn1_7, turn2_7, turn3_7, turn1_1_3, turn1_2_3, turn2_1_3, turn2_2_3, turn3_1_3, turn3_2_3, turn7, turn7_1, turn7_2, turn7_2_1, turn7_1_1, turn7_3, turn8, turn8_1, turn8_2, turn8_3, turn8_1_1, turn8_2_1, turn9, turn9_1, turn9_2, turn9_2_1, turn9_1_1, turn9_3, turn10, turn10_1, turn10_2, turn10_1_1, turn10_3, turn10_2_1
  external circuit: "* Design: MaxCir3"
mesh:
  core: LengthBased RefineInside Objects=[Rotor_Core, Rotor_Core_1] MaxLength=4mm
  CylindricalGap_band: CylindricalGap BandMappingAngle=3deg MovingSideLayers=1 StaticSideLayers=1 Objects=Band
  magnets: LengthBased RefineInside Objects=[Mag_N, Mag_N_2, Mag_N_1, Mag_N_3, Mag_N_2_1, Mag_N_4, Mag_N_3_1, Mag_N_1_1] MaxLength=1mm
  mesh_sheet: LengthBased Objects=[band_top, band_top_1, band_top_1_1, band_top_2, band_top_2_1, band_top_3] MaxLength=1mm
  band: LengthBased RefineInside Objects=Band MaxLength=1mm
  turns: LengthBased RefineInside Objects=[turn1, turn1_1, turn1_1_3, turn1_2, turn1_2_3, turn1_7, turn2, turn2_1, turn2_1_3, turn2_2, turn2_2_3, turn2_7, turn3, turn3_1, turn3_1_3, turn3_2, turn3_2_3, turn3_7, turn7, turn7_1, turn7_1_1, turn7_2, turn7_2_1, turn7_3, turn8, turn8_1, turn8_1_1, turn8_2, turn8_2_1, turn8_3, turn9, turn9_1, turn9_1_1, turn9_2, turn9_2_1, turn9_3, turn10, turn10_1, turn10_1_1, turn10_2, turn10_2_1, turn10_3] MaxLength=0.3mm
  initial mesh: GlobalCurvilinear{Apply} MeshMethod=AnsoftTAU
setups:
  Setup1: Transient NonlinearSolverResidual=0.0001 ScalarPotential="Second Order" SmoothBHCurve StopTime=2*t_per TimeStep=t_per/100 SaveFieldsType=Custom SweepRanges{point 0.001s point 0.01s point 0.01s point 0.01s point 0.01s point 0.01s point 0.01s point 0.01s point 0.01s} NumberSolveSteps=1 RangeStart=0s RangeEnd=0.1s
field calculator expressions:
  B_Z = Fundamental_Quantity(62) | ScalarZ
field plots:
  Mag_B1: B in Rotor_Core on Setup1 : Transient at Time=1000000ns
reports:
  A fazÄ± akÄ±mÄ±, giris ve induced voltajÄ±: InducedVoltage(PhaseA), InputVoltage(PhaseA), Current(PhaseA) vs Time on Setup1 : Transient
  tork: Moving1.Torque vs Time on Setup1 : Transient
  faz akÄ±mlarÄ±: Current(PhaseA), Current(PhaseC), Current(PhaseB) vs Time on Setup1 : Transient
  induced voltages: InducedVoltage(PhaseA), InducedVoltage(PhaseC), InducedVoltage(PhaseB) vs Time on Setup1 : Transient
  Loss Plot 1: SolidLoss vs Time on Setup1 : Transient
